** sch_path: /foss/designs/cmos_opamp/tb_opamp_ac_lc.sch
**.subckt tb_opamp_ac_lc
x1 VDD I_REF VOUT VIN net1 VSS opamp_scheme
VDD VDD 0 2.5
VSS VSS 0 -2.5
I0 VDD I_REF 30u
CL VOUT 0 10p
VIN VIN 0 DC 1.18 AC 1
CIN 0 net1 1t
L5 VOUT net1 1t
**** begin user architecture code

.MODEL N_1u NMOS LEVEL  = 3

+ TOX    = 200E-10         NSUB   = 1E17            GAMMA  = 0.5

+ PHI    = 0.7             VTO    = 0.8             DELTA  = 3.0

+ UO     = 650             ETA    = 3.0E-6          THETA  = 0.1

+ KP     = 120E-6          VMAX   = 1E5             KAPPA  = 0.3

+ RSH    = 0               NFS    = 1E12            TPG    = 1

+ XJ     = 500E-9          LD     = 100E-9

+ CGDO   = 200E-12         CGSO   = 200E-12         CGBO   = 1E-10

+ CJ     = 400E-6          PB     = 1               MJ     = 0.5

+ CJSW   = 300E-12         MJSW   = 0.5

*

.MODEL P_1u PMOS LEVEL  = 3

+ TOX    = 200E-10         NSUB   = 1E17            GAMMA  = 0.6

+ PHI    = 0.7             VTO    = -0.9            DELTA  = 0.1

+ UO     = 250             ETA    = 0               THETA  = 0.1

+ KP     = 40E-6           VMAX   = 5E4             KAPPA  = 1

+ RSH    = 0               NFS    = 1E12            TPG    = -1

+ XJ     = 500E-9          LD     = 100E-9

+ CGDO   = 200E-12         CGSO   = 200E-12         CGBO   = 1E-10

+ CJ     = 400E-6          PB     = 1               MJ     = 0.5

+ CJSW   = 300E-12         MJSW   = 0.5

.param L=1u W1=3.5u W2=3.5u W3=10u W4=10u W5=3u W6=86.6u W7=13u W8=3u Cc=2.5p

.control
ac dec 10 1 100MEG
meas ac max_gain_db MAX vdb(VOUT)
meas ac GBW when vdb(VOUT)=0
meas ac PM find vp(VOUT) when vdb(VOUT)=0

let pm_deg=(pm*180/pi)+180
print pm_deg

write tb_opamp_ac_lc.raw
.endc

**** end user architecture code
**.ends

* expanding   symbol:  opamp_scheme.sym # of pins=6
** sym_path: /foss/designs/cmos_opamp/opamp_scheme.sym
** sch_path: /foss/designs/cmos_opamp/opamp_scheme.sch
.subckt opamp_scheme VDD I_REF VOUT VIN_2 VIN_1 VSS
*.opin VOUT
*.ipin VIN_1
*.ipin VIN_2
*.ipin I_REF
*.ipin VDD
*.ipin VSS
V1 I_REF VBIAS 0
C1 net3 VOUT {Cc}
M1 net1 VIN_1 net2 VSS N_1u w=W1 l=L
M2 net3 VIN_2 net2 VSS N_1u w=W2 l=L
M3 net1 net1 VDD VDD P_1u w=W3 l=L
M4 net3 net1 VDD VDD P_1u w=W4 l=L
M5 net2 VBIAS VSS VSS N_1u w=W5 l=L
M6 VOUT net3 VDD VDD P_1u w=W6 l=L
M7 VOUT VBIAS VSS VSS N_1u w=W7 l=L
M8 VBIAS VBIAS VSS VSS N_1u w=W8 l=L
.ends

.GLOBAL VDD
.GLOBAL VSS
.GLOBAL VIN
.end
